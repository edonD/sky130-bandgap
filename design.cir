* SKY130 Bandgap Voltage Reference
* OTA-based bandgap with PMOS diff pair
* OTA forces V(n1) = V(n2) via negative feedback
* IPTAT = VT * ln(N) / Rptat, where N=8 (BJT area ratio)
* Vref = VBE_Q3 + IPTAT * Rout, where Rout = Rptat * Rratio

.lib "sky130_models/sky130.lib.spice" tt

* Derived parameter
.param rptat_val = {Rptat}
.param rratio_val = {Rratio}

* Supply
Vdd vdd 0 dc 1.8 ac 1
Vss vss 0 0

* === PNP BJT Core ===
XQ1 vss vss n1 vss sky130_fd_pr__pnp_05v5_W0p68L0p68 m=1
XQ2 vss vss ne2 vss sky130_fd_pr__pnp_05v5_W0p68L0p68 m=8
Rptat n2 ne2 {Rptat}

* === PMOS Current Mirror (driven by OTA output ng) ===
XMp1 n1 ng vdd vdd sky130_fd_pr__pfet_01v8 W={Wm}u L={Lm}u nf=1
XMp2 n2 ng vdd vdd sky130_fd_pr__pfet_01v8 W={Wm}u L={Lm}u nf=1
XMp3 vref ng vdd vdd sky130_fd_pr__pfet_01v8 W={Wm}u L={Lm}u nf=1

* === OTA: PMOS diff pair + NMOS active load ===
* n2 = V+ (non-inverting), n1 = V- (inverting) for negative feedback
XMd1 na n2 nsc vdd sky130_fd_pr__pfet_01v8 W={Wd}u L={Ld}u nf=1
XMd2 ng n1 nsc vdd sky130_fd_pr__pfet_01v8 W={Wd}u L={Ld}u nf=1

* Tail current source: resistor from VDD
Rtail vdd nsc {Rtail}

* NMOS active load (current mirror)
XMl1 na na vss vss sky130_fd_pr__nfet_01v8 W={Wl}u L={Ll}u nf=1
XMl2 ng na vss vss sky130_fd_pr__nfet_01v8 W={Wl}u L={Ll}u nf=1

* === Output: VBE (CTAT) + IPTAT * Rout (PTAT) ===
XQ3 vss vss nq3 vss sky130_fd_pr__pnp_05v5_W0p68L0p68 m=1
Rout vref nq3 'rptat_val * rratio_val'

* === Startup: PMOS injects current when vref is low ===
XMs n1 vref vdd vdd sky130_fd_pr__pfet_01v8 W={Wstart}u L=4u nf=1

* Compensation cap for OTA stability
Cc ng vss {Cc}p

* Convergence
.ic v(n1)=0.75 v(n2)=0.75 v(vref)=1.2 v(ng)=1.0 v(nsc)=1.4
.options gmin=1e-11 abstol=1e-11 reltol=0.003 itl1=500

* === Measurements ===
.control
* DC operating point at 27C
op
let vref_val = v(vref)
echo "RESULT_VREF_V" $&vref_val
let pwr = abs(v(vdd) * i(Vdd)) * 1e6
echo "RESULT_POWER_UW" $&pwr
destroy all

* Temperature sweep
dc temp -40 125 1
let vref_max = vecmax(v(vref))
let vref_min = vecmin(v(vref))
let vref_nom = (vref_max + vref_min) / 2
let tempco_val = (vref_max - vref_min) / vref_nom / 165 * 1e6
echo "RESULT_TEMPCO_PPM" $&tempco_val
destroy all

* PSRR: AC analysis
op
ac dec 100 1 1G
meas ac psrr_gain find vdb(vref) at=100
let psrr_val = -psrr_gain
echo "RESULT_PSRR_DB" $&psrr_val
destroy all

* Line regulation
dc Vdd 1.4 2.2 0.02
let vref_first = v(vref)[0]
let vref_last = v(vref)[length(v(vref))-1]
let line_reg = abs(vref_last - vref_first) / 0.8 * 1000
echo "RESULT_LINE_REG_MV_V" $&line_reg

echo "RESULT_DONE"
.endc

.end
